# Ansys Electronics Desktop project, version 2019.1
project variables:
  $Er = $conc_H2O*$Eps_H2O+$conc_TPA*$Eps_TPA
  $tanD = -2*10^-7*($conc_TPA*100)^3+2*10^-5*($conc_TPA*100)^2-0.0006*$conc_TPA*100+0.1351
  $Eps_TPA = 1.7443
  $tanD_TPA = 0.0721
  $Eps_H2O = 75.802
  $tanD_H2O = 0.1334
  $conc_TPA = 1-$conc_H2O
  $conc_H2O = 0.8
materials:
  vacuum: permittivity=1
  Dryer_mix: permittivity=65 dielectric_loss_tangent=0.3 delta_H_freq=2450000000
  Dryer_mix_sweep: permittivity=$Er dielectric_loss_tangent=$tanD delta_H_freq=2450000000

design DryerV8.3 (HFSS, DrivenModal, model units mm)
variables:
  Mix_D = 500mm
  Mix_R = Mix_D/2
  Mix_H = Mix_vol/(pi*Mix_R*Mix_R)
  Cavity_R = Mix_R
  H_factor = 0.4fraction
  Cavity_H = (Mix_H_initial/H_factor)-Mix_H
  Mix_mass = 15kg
  H2O_perc = $conc_H2O
  H2O_dens = 997kg_per_m3
  TPA_perc = $conc_TPA
  TPA_dens = 1520kg_per_m3
  Mix_vol = Mix_mass*H2O_perc/H2O_dens+Mix_mass*TPA_perc/TPA_dens
  WG_h = 54mm
  WG_w = 94mm
  WG_l = 100mm
  WG_posZ = Mix_H_initial/H_factor
  WG_posX = 100mm
  WG_posY = 0mm
  WG_posAngleZ = 0deg
  Mix_H_initial = 71mm
  Blender_Rp = 1mm
  Blender_Rbp = Blender_Rbn/2
  Blender_Rbn = Cavity_R/2
  Blender_Rn = Blender_Rp*1.4143
geometry:
  Mixture [Dryer_mix_sweep] = cylinder(axis=Z, base_centre=(0mm, 0mm, 0mm), radius=Mix_R, height=Mix_H)
  Cavity [vacuum] = cylinder(axis=Z, base_centre=(0mm, 0mm, Mix_H), radius=Cavity_R, height=Cavity_H)
  WG [vacuum] = box(corner=(-WG_h/2 + WG_posX, -WG_w/2 + WG_posY, WG_posZ), size=(WG_h, WG_w, WG_l))
  WG.rotate(axis=Z, angle=WG_posAngleZ)
  Torus_mid = torus(axis=Z, centre=(0mm, 0mm, Mix_H), major_radius=Blender_Rbn, minor_radius=Blender_Rn)
  Torus_int = torus(axis=Z, centre=(0mm, 0mm, Mix_H), major_radius=Blender_Rbp, minor_radius=Blender_Rp)
  Torus_ext = torus(axis=Z, centre=(0mm, 0mm, Mix_H), major_radius=Blender_Rbp*3, minor_radius=Blender_Rp)
  Mixture.unite(Torus_ext, Torus_int)
  Mixture.subtract(Torus_mid)
  Mixture_1 = Mixture.copy()
  Cavity.subtract(Mixture_1)
boundaries and excitations:
  1: Wave Port Faces=WG.face(1 of 6) NumModes=1 Modes{Mode1{IntLine{centre of WG.face(1 of 6) -> middle of WG.edge(1 of 12)} CharImp=Zwave}}
setups:
  Setup_2_45GHz: HfssDriven Frequency=2.45GHz MaxDeltaS=0.02 MaximumPasses=6 MinimumPasses=1 MinimumConvergedPasses=1 PercentRefinement=30 BasisOrder=-1 PortAccuracy=2
    sweep Sweep_Disc: 2.35GHz to 2.55GHz step 100MHz; Type=Discrete SaveFields
    sweep Sweep_Int: 2.35GHz to 2.55GHz step 100MHz; disabled Type=Interpolating InterpTolerance=0.5 InterpMaxSolns=250 InterpUsePortImped=false PassivityErrorTolerance=0.0001
source amplitudes:
  1:1: 1W 0deg
optimetrics:
  ParametricSetup_Blender_Rp_sweep: Parametric Sim._Setups=[Setup_2_45GHz]
    sweep Blender_Rp: LIN 1mm 15mm 2mm
field calculator expressions:
  Vloss = VolumeLossDensity | EnterVolume(Mixture) | VolumeValue | Integrate
reports:
  Plot - Vloss vs Blender: Vloss vs Blender_Rp on Setup_2_45GHz : LastAdaptive [Phase=0deg Freq=2.45GHz]; markers m1 at 0.1mm, m2 at 1mm, m3 at 3mm, m4 at 5mm, m5 at 7mm, m6 at 9mm, m7 at 11mm, m8 at 13mm, m9 at 15mm
